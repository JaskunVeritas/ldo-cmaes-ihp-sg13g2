** sch_path: /home/jaskun/designs/1iee34/tb_ldo_PSRR.sch
**.subckt tb_ldo_PSRR
V1 VDD GND dc 1.5 ac 1
V2 VSS GND 0
V3 VREF VSS 0.6
R3 VLDO VSS 240 m=1
x1 VDD VREF net1 VLDO net1 VSS LDO1
**** begin user architecture code

.param temp=27
.options savecurrents
.op
.save all
+ @n.x1.xmG.nsg13_lv_pmos[ids]
+ @n.x1.xmG.nsg13_lv_pmos[gm]
+ @n.x1.xmG.nsg13_lv_pmos[gds]
+ @n.x1.xm6.nsg13_lv_pmos[gds]
+ @n.x1.xm6.nsg13_lv_pmos[gm]
+ @n.x1.xm5.nsg13_lv_nmos[ids]
+ @n.x1.xm5.nsg13_lv_nmos[gm]
+ @n.x1.xm5.nsg13_lv_nmos[gds]
+ @n.x1.xm8.nsg13_lv_nmos[ids]
+ @n.x1.xm7.nsg13_lv_nmos[ids]
+ @n.x1.xm7.nsg13_lv_nmos[gm]
+ @n.x1.xm7.nsg13_lv_nmos[gds]
+ i(x1.r1)
+ i(x1.r2)

.control
  set filetype=ascii
  op
  write tb_ldo_PSRR_OP_03.raw v(vdd) v1#branch @r3[i]
  ac dec 160 10 1g
  set units=degress
  let PSRR = 1/VLDO
  write tb_ldo_PSRR_03.raw vdb(PSRR) vp(PSRR)
  set appendwrite
.endc

.lib cornerMOSlv.lib mos_tt

**** end user architecture code
**.ends

* expanding   symbol:  LDO1.sym # of pins=6
** sym_path: /home/jaskun/designs/1iee34/LDO1.sym
** sch_path: /home/jaskun/designs/1iee34/LDO1.sch
.subckt LDO1 VDD VREF+ VREF- VLDO VRET VSS
*.iopin VREF+
*.iopin VLDO
*.iopin VDD
*.iopin VREF-
*.iopin VSS
*.iopin VRET
C1 VLDO VSS 1000.0n m=1
CC net4 net1 3.666349378452877e-05n m=1
R1 VLDO VRET 21.49k m=1
R2 VRET VSS 21.49k m=1
C3 VLDO net5 5n m=1
R3 net1 net5 30k m=1
XMG VLDO net1 VDD VDD sg13_lv_pmos w=250.0u l=0.13u ng=13 m=1 mm_ok=1
XM3 net3 net3 VDD VDD sg13_lv_pmos w=14.74u l=32.58u ng=2 m=1 mm_ok=1
XM4 net4 net3 VDD VDD sg13_lv_pmos w=14.74u l=32.58u ng=2 m=1 mm_ok=1
XM6 net1 net4 VDD VDD sg13_lv_pmos w=3.58u l=1.5u ng=1 m=1 mm_ok=1
XM1 net2 VREF+ net3 VSS sg13_lv_nmos w=176.34u l=8.55u ng=18 m=1 mm_ok=1
XM2 net2 VREF- net4 VSS sg13_lv_nmos w=176.34u l=8.55u ng=18 m=1 mm_ok=1
XM5 VSS VG net2 VSS sg13_lv_nmos w=2.2u l=2.0u ng=1 m=1 mm_ok=1
XM7 VSS VG net1 VSS sg13_lv_nmos w=4.4u l=2.0u ng=1 m=1 mm_ok=1
XM8 VSS VG VG VSS sg13_lv_nmos w=2.75u l=2.0u ng=1 m=1 mm_ok=1
XM10 net6 net6 VDD VDD sg13_lv_pmos w=2u l=8u ng=1 m=1 mm_ok=1
XM11 VG VDD net6 VSS sg13_lv_nmos w=2u l=8u ng=1 m=1 mm_ok=1
.ends

.GLOBAL GND
.end
